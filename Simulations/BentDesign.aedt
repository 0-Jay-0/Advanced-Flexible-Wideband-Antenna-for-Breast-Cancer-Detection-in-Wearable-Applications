# Ansys Electronics Desktop project, version 2024.2
materials:
  vacuum: permittivity=1
  copper: permeability=0.999991 conductivity=58000000
  Rogers RO3003 (tm): permittivity=3 dielectric_loss_tangent=0.0013
  Rogers RT/duroid 5880 (tm): permittivity=2.2 dielectric_loss_tangent=0.0009
  Breast_Skin: permittivity=17.7 dielectric_loss_tangent=0.93 delta_H_freq=33000000000
  Breast_Fat: permittivity=3.4 dielectric_loss_tangent=0.16 delta_H_freq=33000000000
  Breast_FibroglandularTissue: permittivity=16 dielectric_loss_tangent=0.94 delta_H_freq=33000000000
  Tumor: permittivity=18 dielectric_loss_tangent=1.05 delta_H_freq=33000000000
  Jeans: permittivity=1.7 dielectric_loss_tangent=0.025
  Felt: permittivity=2.5 dielectric_loss_tangent=0.023
  Cotton: permittivity=1.6 dielectric_loss_tangent=0.02
  Jute: permittivity=1.87 dielectric_loss_tangent=0.052

design HFSSDesign1 (HFSS, HFSS Terminal Network, model units mm)
variables:
  l_sub = 30.75mm
  w_sub = 30mm
  w_sheet = l_sub
  l_sheet = 10.99999975mm
  w_port = 5.29999975mm
  l_port = 4.03499975mm
  t_sub = 0.7mm
  t_patch = 0.035mm
  phan_rad = 80mm
  phan_off = 5mm
  phan_skin_t = 0.5mm
  phan_fat_t = 0.5mm
  Tumor_x = -15mm
  Tumor_y = 25mm
  Tumor_z = -30mm
  Tumor_rad = 15mm
  areo_rad = 1mm
  t_sub_rogers = 1.6mm
geometry:
  coordinate_system patch_offset = origin=(0mm, 30mm, -t_patch-4.7mm) x=(1mm, 0mm, 0mm) y=(0mm, 1mm, 0mm)
  Patch = imported_body(C:\Users\admin\Desktop\1.stp) in patch_offset
  coordinate_system Substrate_xmid_ybase_ztop = origin=(0, 16mm, 0) x=(1mm, 0mm, 0mm) y=(0mm, 1mm, 0mm)
  Sheet = rectangle(corner=(-w_sheet/2, -0.135757mm, t_sub), x_size=w_sheet, y_size=l_sheet) in Substrate_xmid_ybase_ztop
  coordinate_system port_base = origin=(0mm, -0.16656386mm, 0.83281914mm) x=(1mm, 0mm, 0mm) y=(0mm, 1mm, 0mm) in Substrate_xmid_ybase_ztop
  Port = rectangle(corner=(-w_port/2, -0.135757mm, -l_port/2), z_size=l_port, x_size=w_port) in port_base
  Box1 = box(corner=(0mm, 0mm, t_sub), size=(l_sub/2, w_sub, t_patch)) in Substrate_xmid_ybase_ztop
  Patch.subtract(Box1)
  coordinate_system patch_xmid_ybase_zbase = origin=(0mm, 0mm, -t_sub) x=(1mm, 0mm, 0mm) y=(0mm, 1mm, 0mm) in Substrate_xmid_ybase_ztop
  Patch_1 = Patch.duplicate_mirror(point=(0mm, 0mm, 0mm), normal=(1mm, 0mm, 0mm)) in patch_xmid_ybase_zbase
  coordinate_system Phan_zbase = origin=(0mm, 0mm, phan_rad+phan_off) x=(1mm, 0mm, 0mm) y=(0mm, 1mm, 0mm)
  coordinate_system Phan_ztop = origin=(0mm, 0mm, -(phan_rad-phan_skin_t)) x=(1mm, 0mm, 0mm) y=(0mm, 1mm, 0mm) in Phan_zbase
  RadiatingSurface [vacuum] = region(absolute_offset=20mm on all sides) in Phan_ztop
  Patch.unite(Patch_1)
  Bend_structure = cylinder(axis=X, base_centre=(-phan_rad, 0, phan_rad), radius=phan_rad, height=phan_rad*2)
  Substrate [Jute] = rectangle(corner=(-l_sub/2, 0mm, 0), x_size=l_sub, y_size=w_sub) in Substrate_xmid_ybase_ztop
  Bend_structure_1 = Bend_structure.copy()
  Bend_structure_1.delete()
  Sheet.wrap_sheet(SheetBody=267 TargetBody=12023)
  Bend_structure_2 = Bend_structure.copy()
  [Bend_structure, Bend_structure_2].delete()
  Substrate.wrap_sheet(SheetBody=11989 TargetBody=12040)
  Substrate.thicken(t_sub)
  Patch_ [copper] = object_from(?.face(at (0, 29.7882, -4)))
  Patch.delete()
  Substrate_1 = Substrate.copy()
  Substrate_1.delete()
  Patch_.wrap_sheet(SheetBody=12084 TargetBody=12198)
  Patch_.thicken(0.035mm)
  coordinate_system curved_origin_1 = origin=(0mm, 12.794744mm, 1.0297871mm) x=(1mm, 0mm, 0mm) y=(0mm, 1mm, 0mm)
  group 1 = Patch_
boundaries and excitations:
  PerfE1: Perfect E Objects=Sheet
  Open1: Radiation Objects=RadiatingSurface
  1: Lumped Port Objects=Port LumpedPortType=Modal Modes{Mode1{IntLine{(0, 15.697679, 0.83281914) -> (0, 15.697679, -1.1846807)} CharImp=Zpi}} Impedance=50ohm
setups:
  Setup1: HfssDriven MultipleAdaptiveFreqsSetup{Low=2GHz High=20GHz} MaxDeltaS=0.02 MaximumPasses=6 MinimumPasses=1 MinimumConvergedPasses=1 PercentRefinement=30 BasisOrder=1 PortAccuracy=2 DrivenSolverType="Direct Solver"
    sweep Sweep: 2GHz to 15GHz, 401 points; Type=Fast SaveFields
source amplitudes:
  1:1: 1V 0deg
radiation setups:
  3D: Infinite Sphere Theta=0deg..180deg step 2deg Phi=-180deg..180deg step 2deg CoordSystem=Phan_ztop
  Elevation: Infinite Sphere Theta=-180deg..180deg step 1deg Phi=0deg..90deg step 90deg CoordSystem=Phan_ztop
  Azimuth: Infinite Sphere Theta=90deg..90deg step 0deg Phi=-180deg..180deg step 1deg CoordSystem=Phan_ztop
field plots:
  Vector_Jsurf1: Jsurf over Patch_.face(all 20) on Setup1 : LastAdaptive at Freq=11GHz Phase=0deg
  Mag_E1: E Field over Patch_.face(all 20) on Setup1 : LastAdaptive at Freq=11GHz Phase=0deg
reports:
  S Parameter Plot 1: dB(S(1,1)) vs Freq on Setup1 : Sweep

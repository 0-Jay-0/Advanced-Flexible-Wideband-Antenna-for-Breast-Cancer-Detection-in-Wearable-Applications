# Ansys Electronics Desktop project, version 2024.2
materials:
  vacuum: permittivity=1
  copper: permeability=0.999991 conductivity=58000000
  Rogers RO3003 (tm): permittivity=3 dielectric_loss_tangent=0.0013
  Rogers RT/duroid 5880 (tm): permittivity=2.2 dielectric_loss_tangent=0.0009
  Breast_Skin: permittivity=17.7 dielectric_loss_tangent=0.93 delta_H_freq=33000000000
  Breast_Fat: permittivity=3.4 dielectric_loss_tangent=0.16 delta_H_freq=33000000000
  Breast_FibroglandularTissue: permittivity=16 dielectric_loss_tangent=0.94 delta_H_freq=33000000000
  Tumor: permittivity=18 dielectric_loss_tangent=1.05 delta_H_freq=33000000000
  Jeans: permittivity=1.7 dielectric_loss_tangent=0.025
  Felt: permittivity=2.5 dielectric_loss_tangent=0.023
  Cotton: permittivity=1.6 dielectric_loss_tangent=0.02
  Jute: permittivity=1.87 dielectric_loss_tangent=0.052

design HFSSDesign1 (HFSS, HFSS Terminal Network, model units mm)
variables:
  l_sub = 30.75mm
  w_sub = 30mm
  w_sheet = l_sub
  l_sheet = 10.99999975mm
  w_port = 5.29999975mm
  l_port = 4.03499975mm
  t_sub = 0.7mm
  t_patch = 0.035mm
  phan_rad = 80mm
  phan_off = 5mm
  phan_skin_t = 0.5mm
  phan_fat_t = 0.5mm
  Tumor_x = -15mm
  Tumor_y = 25mm
  Tumor_z = -30mm
  Tumor_rad = 15mm
  areo_rad = 1mm
  t_sub_rogers = 1.6mm
geometry:
  coordinate_system patch_offset = origin=(0mm, 0mm, -t_patch-0.7mm) x=(1mm, 0mm, 0mm) y=(0mm, 1mm, 0mm)
  Patch [copper] = imported_body(C:\Users\admin\Desktop\1.stp) in patch_offset
  coordinate_system Substrate_xmid_ybase_ztop = origin=(0, 0.8728401916mm-0.49784mm-l_sub/2, 0) x=(1mm, 0mm, 0mm) y=(0mm, 1mm, 0mm)
  Substrate [Jute] = box(corner=(-l_sub/2, 0, 0), size=(l_sub, w_sub, t_sub)) in Substrate_xmid_ybase_ztop
  Sheet = rectangle(corner=(-w_sheet/2, 0, t_sub), x_size=w_sheet, y_size=l_sheet) in Substrate_xmid_ybase_ztop
  Port = rectangle(corner=(-w_port/2, 0mm, -l_port/2), z_size=l_port, x_size=w_port) in Substrate_xmid_ybase_ztop
  Box1 = box(corner=(0mm, 0mm, t_sub), size=(l_sub/2, w_sub, t_patch)) in Substrate_xmid_ybase_ztop
  Patch.subtract(Box1)
  coordinate_system patch_xmid_ybase_zbase = origin=(0mm, 0mm, -t_sub) x=(1mm, 0mm, 0mm) y=(0mm, 1mm, 0mm) in Substrate_xmid_ybase_ztop
  Patch_1 = Patch.duplicate_mirror(point=(0mm, 0mm, 0mm), normal=(1mm, 0mm, 0mm)) in patch_xmid_ybase_zbase
  coordinate_system Phan_zbase = origin=(0mm, 0mm, phan_rad+phan_off) x=(1mm, 0mm, 0mm) y=(0mm, 1mm, 0mm)
  coordinate_system Phan_ztop = origin=(0mm, 0mm, -(phan_rad-phan_skin_t)) x=(1mm, 0mm, 0mm) y=(0mm, 1mm, 0mm) in Phan_zbase
  RadiatingSurface [vacuum] = region(absolute_offset=20mm on all sides) in Phan_ztop
  Patch.unite(Patch_1)
  group 1 = Patch
boundaries and excitations:
  PerfE1: Perfect E Objects=Sheet
  Open1: Radiation Objects=RadiatingSurface
  1: Lumped Port Objects=Port LumpedPortType=Modal Modes{Mode1{IntLine{(0, -15, 0) -> (0, -15, -2.017499875)} CharImp=Zpi}} Impedance=50ohm
setups:
  Setup1: HfssDriven MultipleAdaptiveFreqsSetup{Low=2GHz High=20GHz} MaxDeltaS=0.02 MaximumPasses=6 MinimumPasses=1 MinimumConvergedPasses=1 PercentRefinement=30 BasisOrder=1 PortAccuracy=2 DrivenSolverType="Direct Solver"
    sweep Sweep: 2GHz to 15GHz, 401 points; Type=Fast SaveFields
source amplitudes:
  1:1: 1V 0deg
radiation setups:
  3D: Infinite Sphere Theta=0deg..180deg step 2deg Phi=-180deg..180deg step 2deg CoordSystem=Phan_ztop
  Elevation: Infinite Sphere Theta=-180deg..180deg step 1deg Phi=0deg..90deg step 90deg CoordSystem=Phan_ztop
  Azimuth: Infinite Sphere Theta=90deg..90deg step 0deg Phi=-180deg..180deg step 1deg CoordSystem=Phan_ztop
field plots:
  Vector_Jsurf2: Jsurf over Patch.face(all 20) on Setup1 : LastAdaptive at Freq=11GHz Phase=0deg
  Mag_E1: E Field over Patch.face(all 20) on Setup1 : LastAdaptive at Freq=11GHz Phase=0deg
reports:
  S Parameter Plot 1: dB(S(1,1)) vs Freq on Setup1 : Sweep

# Ansys Electronics Desktop project, version 2024.2
project datasets:
  $Permittivity_Healthy_Fat: units GHz, : (2000000000, 5.33) (2500000000, 5.27) (3000000000, 5.22) (3500000000, 5.17) (4000000000, 5.12) (4500000000, 5.08) (5000000000, 5.03) (6000000000, 4.94) (7000000000, 4.85) (8000000000, 4.76) (9000000000, 4.68) (10000000000, 4.6) (12000000000, 4.46) (14000000000, 4.33) (16000000000, 4.21) (20000000000, 4)
  $Conductivity_Healthy_Fat: units GHz, : (2000000000, 0.0859) (3000000000, 0.13) (4000000000, 0.183) (5000000000, 0.242) (6000000000, 0.306) (7000000000, 0.374) (8000000000, 0.443) (9000000000, 0.514) (10000000000, 0.585) (20000000000, 1.26)
  $Permittivity_Healthy_Fibroglandular: units GHz, : (2000000000, 52.1) (3000000000, 50.8) (5000000000, 48.1) (7000000000, 45.7) (10000000000, 42.9) (15000000000, 38.6) (20000000000, 35.3)
  $Conductivity_Healthy_Fibroglandular: units GHz, : (2000000000, 0.5) (4000000000, 0.57) (6000000000, 0.64) (8000000000, 0.71) (10000000000, 0.78) (12000000000, 0.84) (14000000000, 0.9) (16000000000, 0.95) (18000000000, 1) (20000000000, 1.05)
  $Permittivity_Healthy_Skin: units GHz, : (2000000000, 57.8) (3000000000, 56.4) (4000000000, 54.9) (5000000000, 53.3) (6000000000, 51.7) (7000000000, 50.1) (8000000000, 48.4) (9000000000, 46.8) (10000000000, 45.1) (20000000000, 31.6)
  $Conductivity_Healthy_Skin: units GHz, : (2000000000, 1.63) (3000000000, 2.44) (4000000000, 3.46) (5000000000, 4.66) (6000000000, 6) (7000000000, 7.44) (8000000000, 8.96) (9000000000, 10.5) (10000000000, 12.1) (20000000000, 27.2)
materials:
  vacuum: permittivity=1
  copper: permeability=0.999991 conductivity=58000000 mass_density=8933
  Rogers RO3003 (tm): permittivity=3 dielectric_loss_tangent=0.0013
  Rogers RT/duroid 5880 (tm): permittivity=2.2 dielectric_loss_tangent=0.0009
  Breast_Skin: permittivity=pwl($Permittivity_Healthy_Skin,Freq) conductivity=pwl($Conductivity_Healthy_Skin,Freq) delta_H_freq=33000000000
  Breast_Fat: permittivity=pwl($Permittivity_Healthy_Fat,Freq) conductivity=pwl($Conductivity_Healthy_Fat,Freq) delta_H_freq=33000000000
  Breast_FibroglandularTissue: permittivity=pwl($Permittivity_Healthy_Fibroglandular,Freq) conductivity=pwl($Conductivity_Healthy_Fibroglandular,Freq) delta_H_freq=33000000000
  Tumor: permittivity=18 dielectric_loss_tangent=1.05 delta_H_freq=33000000000
  Jeans: permittivity=1.7 dielectric_loss_tangent=0.025
  Felt: permittivity=2.5 dielectric_loss_tangent=0.023
  Cotton: permittivity=1.6 dielectric_loss_tangent=0.02
  Jute: permittivity=1.87 dielectric_loss_tangent=0.052

design HFSSDesign1 (HFSS, HFSS Terminal Network, model units mm)
variables:
  l_sub = 30.75mm
  w_sub = 30mm
  w_sheet = l_sub
  l_sheet = 10.99999975mm
  w_port = 5.29999975mm
  l_port = 4.03499975mm
  t_sub = 0.7mm
  t_patch = 0.035mm
  phan_rad = 80mm
  phan_off = 5mm
  phan_skin_t = 0.5mm
  phan_fat_t = 0.5mm
  Tumor_x = -15mm
  Tumor_y = 25mm
  Tumor_z = -30mm
  Tumor_rad = 15mm
  areo_rad = 1mm
  t_sub_rogers = 1.6mm
geometry:
  coordinate_system patch_offset = origin=(0mm, 0mm, -t_patch-0.7mm) x=(1mm, 0mm, 0mm) y=(0mm, 1mm, 0mm)
  Patch [copper] = imported_body(C:\Users\admin\Desktop\1.stp) in patch_offset
  coordinate_system Substrate_xmid_ybase_ztop = origin=(0, 0.8728401916mm-0.49784mm-l_sub/2, 0) x=(1mm, 0mm, 0mm) y=(0mm, 1mm, 0mm)
  Substrate [Jute] = box(corner=(-l_sub/2, 0, 0), size=(l_sub, w_sub, t_sub)) in Substrate_xmid_ybase_ztop
  Sheet = rectangle(corner=(-w_sheet/2, 0, t_sub), x_size=w_sheet, y_size=l_sheet) in Substrate_xmid_ybase_ztop
  Port = rectangle(corner=(-w_port/2, 0mm, -l_port/2), z_size=l_port, x_size=w_port) in Substrate_xmid_ybase_ztop
  Box1 = box(corner=(0mm, 0mm, t_sub), size=(l_sub/2, w_sub, t_patch)) in Substrate_xmid_ybase_ztop
  Patch.subtract(Box1)
  coordinate_system patch_xmid_ybase_zbase = origin=(0mm, 0mm, -t_sub) x=(1mm, 0mm, 0mm) y=(0mm, 1mm, 0mm) in Substrate_xmid_ybase_ztop
  Patch_1 = Patch.duplicate_mirror(point=(0mm, 0mm, 0mm), normal=(1mm, 0mm, 0mm)) in patch_xmid_ybase_zbase
  coordinate_system Phan_zbase = origin=(0mm, 0mm, phan_rad+phan_off) x=(1mm, 0mm, 0mm) y=(0mm, 1mm, 0mm)
  Phantom_Skin = polyline((phan_rad, 0mm, 0mm) (4.8985872e-15mm, 1.2864981e-14mm, -80mm) (-80mm, 1.5755058e-30mm, -9.7971744e-15mm), AngularArc from point 0 over 3 centre=(0mm, 0mm, 0mm) angle=-180deg plane=ZX) in Phan_zbase
  Polyline2 = polyline((phan_rad, 0mm, 0mm) (-phan_rad, 0mm, 0mm)) in Phan_zbase
  Phantom_Skin.unite(Polyline2)
  Phantom_Skin.cover_lines()
  Polyline3 = polyline(xyz in mm: (0, 70, 0) (-1.1256859e-14, 1.9829386e-14, -70) (-4.2862638e-15, -70, -2.411565e-14), AngularArc from point 0 over 3 centre=(0mm, 0mm, 0mm) angle=-180deg plane=YZ) in Phan_zbase
  Phantom_Skin.sweep_along_path(Polyline3)
  Phantom_Fibroglandular [Breast_FibroglandularTissue] = polyline(((phan_rad-phan_skin_t-phan_fat_t), 0mm, 0mm) (4.8373549e-15mm, 1.2704169e-14mm, -79mm) (-79mm, 1.555812e-30mm, -9.6747097e-15mm), AngularArc from point 0 over 3 centre=(0mm, 0mm, 0mm) angle=-180deg plane=ZX) in Phan_zbase
  Polyline8 = polyline((-(phan_rad-phan_skin_t-phan_fat_t), 0mm, 0mm) ((phan_rad-phan_skin_t-phan_fat_t), 0mm, 0mm)) in Phan_zbase
  Phantom_Fibroglandular.unite(Polyline8)
  Phantom_Fibroglandular.cover_lines()
  Polyline9 = polyline(xyz in mm: (0, 230, 0) (-3.6986821e-14, 6.5153697e-14, -230) (-1.4083438e-14, -230, -7.9237136e-14), AngularArc from point 0 over 3 centre=(0mm, 0mm, 0mm) angle=-180deg plane=YZ) in Phan_zbase
  Phantom_Fibroglandular.sweep_along_path(Polyline9)
  Phantom_Fat [Breast_Fat] = polyline(((phan_rad-phan_skin_t), 0mm, 0mm) (4.867971e-15mm, 1.2784575e-14mm, -79.5mm) (-79.5mm, 1.5656589e-30mm, -9.7359421e-15mm), AngularArc from point 0 over 3 centre=(0mm, 0mm, 0mm) angle=-180deg plane=ZX) in Phan_zbase
  Polyline11 = polyline(((phan_rad-phan_skin_t), 0mm, 0mm) (-(phan_rad-phan_skin_t), 0mm, 0mm)) in Phan_zbase
  Phantom_Fat.unite(Polyline11)
  Phantom_Fat.cover_lines()
  Polyline12 = polyline(xyz in mm: (0, 210, 0) (-3.3770576e-14, 5.9488158e-14, -210) (-1.2858791e-14, -210, -7.234695e-14), AngularArc from point 0 over 3 centre=(0mm, 0mm, 0mm) angle=-180deg plane=YZ) in Phan_zbase
  Phantom_Fat.sweep_along_path(Polyline12)
  Phantom_Fat_1 = Phantom_Fat.copy()
  Phantom_Skin.subtract(Phantom_Fat_1)
  Phantom_Fibroglandular_1 = Phantom_Fibroglandular.copy()
  Phantom_Fat.subtract(Phantom_Fibroglandular_1)
  coordinate_system Phan_ztop = origin=(0mm, 0mm, -(phan_rad-phan_skin_t)) x=(1mm, 0mm, 0mm) y=(0mm, 1mm, 0mm) in Phan_zbase
  Phantom_Skin_1 [Breast_Skin] = polyline((areo_rad, 0mm, 0mm) (6.123234e-17mm, 1.6081226e-16mm, -1mm) (-1mm, 1.9693823e-32mm, -1.2246468e-16mm), AngularArc from point 0 over 3 centre=(0mm, 0mm, 0mm) angle=-180deg plane=ZX) in Phan_ztop
  Polyline14 = polyline((areo_rad, 0mm, 0mm) (-areo_rad, 0mm, 0mm)) in Phan_ztop
  Phantom_Skin_1.unite(Polyline14)
  Phantom_Skin_1.cover_lines()
  Polyline15 = polyline(xyz in mm: (0, 2, 0) (-3.2162453e-16, 5.6655389e-16, -2) (-1.2246468e-16, -2, -6.8901857e-16), AngularArc from point 0 over 3 centre=(0mm, 0mm, 0mm) angle=-180deg plane=YZ) in Phan_ztop
  Phantom_Skin_1.sweep_along_path(Polyline15)
  Phantom_Skin_1.unite(Phantom_Skin)
  RadiatingSurface [vacuum] = region(absolute_offset=20mm on all sides) in Phan_ztop
  Patch.unite(Patch_1)
  group 1 = Patch
boundaries and excitations:
  PerfE1: Perfect E Objects=Sheet
  Open1: Radiation Objects=RadiatingSurface
  1: Lumped Port Objects=Port LumpedPortType=Modal Modes{Mode1{IntLine{(0, -15, 0) -> (0, -15, -2.017499875)} CharImp=Zpi}} Impedance=50ohm
setups:
  Setup1: HfssDriven MultipleAdaptiveFreqsSetup{Low=2GHz High=20GHz} MaxDeltaS=0.02 MaximumPasses=6 MinimumPasses=1 MinimumConvergedPasses=1 PercentRefinement=30 BasisOrder=1 PortAccuracy=2 DrivenSolverType="Direct Solver"
    sweep Sweep: 2GHz to 15GHz, 401 points; Type=Fast SaveFields
source amplitudes:
  1:1: 1V 0deg
radiation setups:
  3D: Infinite Sphere Theta=0deg..180deg step 2deg Phi=-180deg..180deg step 2deg CoordSystem=Phan_ztop
  Elevation: Infinite Sphere Theta=-180deg..180deg step 1deg Phi=0deg..90deg step 90deg CoordSystem=Phan_ztop
  Azimuth: Infinite Sphere Theta=90deg..90deg step 0deg Phi=-180deg..180deg step 1deg CoordSystem=Phan_ztop
field plots:
  Mag_E1: E Field on Setup1 : LastAdaptive at Freq=11GHz Phase=0deg
  Average_SAR1: SAR Field in Phantom_Fat, Phantom_Fibroglandular, Phantom_Skin_1 on Setup1 : LastAdaptive at Freq=11GHz Phase=0deg
  Vector_Jsurf1: Jsurf over Patch.face(all 20) on Setup1 : LastAdaptive at Freq=11GHz Phase=0deg
reports:
  S Parameter Plot 1: dB(S(1,1)) vs Freq on Setup1 : Sweep
